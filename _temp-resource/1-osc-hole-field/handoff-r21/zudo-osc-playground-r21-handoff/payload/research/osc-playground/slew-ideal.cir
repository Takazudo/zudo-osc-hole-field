* R21 post-hold RC only. Not a full S&H, protection, power, or IC model.
* ngspice-compatible starting test deck. Not executed in this environment.
.param RPOT=500k RMIN=2.2k CSLEW=500n
Vheld RAW 0 PWL(0 0 0.2 0 0.200001 5 0.85 5 0.850001 -3 1.4 -3 1.400001 2 2 2 2.000001 0)
Epre BUF 0 RAW 0 1
Rmin BUF RIN {RMIN}
Rpot RIN LAG {RPOT}
Cglide LAG 0 {CSLEW}
Epost OUT 0 LAG 0 1
Rload OUT 0 100k
.tran 100u 2.6
.control
run
write slew-ideal.raw
.endc
.end
