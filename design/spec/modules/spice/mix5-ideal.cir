MIX5 five equal inputs, ideal amplifiers; +5 V each
V1 IN1 0 5
V2 IN2 0 5
V3 IN3 0 5
V4 IN4 0 5
V5 IN5 0 5
R1 IN1 SUM_NODE 100k
R2 IN2 SUM_NODE 100k
R3 IN3 SUM_NODE 100k
R4 IN4 SUM_NODE 100k
R5 IN5 SUM_NODE 100k
RF SUM_PRELEVEL SUM_NODE 40k
ESUM SUM_PRELEVEL 0 0 SUM_NODE 1e6
* LEVEL is a chosen pot position in this ideal deck, not hardware.
RLEVEL_TOP SUM_PRELEVEL LEVEL 5k
RLEVEL_BOTTOM LEVEL 0 5k
ELEVEL LEVEL_BUFFERED 0 LEVEL 0 1
RRESTORE LEVEL_BUFFERED RESTORE_NODE 100k
RRESTORE_FB SUM_OUT RESTORE_NODE 100k
ERESTORE SUM_OUT 0 0 RESTORE_NODE 1e6
.op
.print op v(SUM_PRELEVEL) v(SUM_OUT)
.end
