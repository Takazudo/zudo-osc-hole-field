Unvalidated wavefolder model: wavefolder-dc-f0p25-b5
* Spec-derived signal path and bias servo; ideal limited amplifiers.
.include "design/spec/modules/spice/filter-model/LM13700.MOD"
VP P_12V 0 12
VN N_12V 0 -12
VREF5 REF5 0 5
VREFN5 REFN5 0 -5
VIN IN_BUFFER 0 0
VMANUAL FOLD_MANUAL 0 0.25
VDEPTH FOLD_DEPTH 0 0
VBIAS BIAS_MANUAL 0 5
VBIASCV BIAS_BUFFER 0 0
VOFFSET OFFSET_TRIM 0 0.332
RCORE_R_CONTROL_MANUAL_0 FOLD_MANUAL CONTROL_SUM 100000
RCORE_R_CONTROL_DEPTH_0 FOLD_DEPTH CONTROL_SUM 100000
RCORE_R_CONTROL_FB_0 CONTROL_NEG CONTROL_SUM 100000
RCORE_R_CONTROL_INV_IN_0 CONTROL_NEG CONTROL_INV 100000
RCORE_R_CONTROL_INV_FB_0 CONTROL_RAW CONTROL_INV 100000
RCORE_R_CONTROL_LIMIT_0 CONTROL_RAW CONTROL_CLAMP 10000
DCLOW 0 CONTROL_CLAMP SCHOTTKY
DCHIGH CONTROL_CLAMP REF5 SCHOTTKY
RCORE_R_REF25_TOP_0 REF5 REF25 100000
RCORE_R_REF25_BOTTOM_0 REF25 0 100000
RCORE_R_TARGET_IN_0 COMMAND TARGET_SUM 100000
RCORE_R_TARGET_FB_0 TARGET TARGET_SUM 100000
RCORE_R_BIAS_SENSE_0 REF5 EMITTER 12400
RCORE_R_BASE_LIMIT_0 BASE_DRIVE BASE 10000
QBIAS CURRENT_SOURCE BASE EMITTER GENERIC_PNP
DREVERSE BASE EMITTER FOLD_NEG
CCORE_C_SERVO_COMP_0 BASE_DRIVE EMITTER 1e-10
RCORE_R_IABC_LIMIT_0 CURRENT_SOURCE IABC 22000
RCORE_R_INPUT_ATTEN_TOP_0 IN_BUFFER OTA_SIGNAL 100000
RCORE_R_INPUT_ATTEN_BOTTOM_0 OTA_SIGNAL 0 200
RCORE_R_OFFSET_FEED_0 OFFSET_TRIM OTA_OFFSET 470000
RCORE_R_OFFSET_RETURN_0 OTA_OFFSET 0 1000
RCORE_R_UNUSED_BIAS_0 UNUSED_IABC N_12V 100000
RCORE_R_PRE_GAIN_FIXED_0 PRE_GAIN PRE_GAIN_TRIM 49900
RGAIN_TRIM PRE_GAIN_TRIM PRE_GAIN_SUM 5k
RCORE_R_DRIVE_SIGNAL_0 PRE_GAIN FOLDER_SUM 100000
RCORE_R_DRIVE_BIAS_MANUAL_0 BIAS_MANUAL FOLDER_SUM 1e+06
RCORE_R_DRIVE_BIAS_BUFFER_0 BIAS_BUFFER FOLDER_SUM 1e+06
RCORE_R_DRIVE_FB_0 FOLDER_NEG FOLDER_SUM 100000
RCORE_R_DRIVE_INV_IN_0 FOLDER_NEG DRIVE_INV_SUM 100000
RCORE_R_DRIVE_INV_FB_0 FOLDER_DRIVE DRIVE_INV_SUM 100000
RCORE_R_F1_CLIP_FEED_0 FOLDER_DRIVE F1_CLIP 10000
DCORE_F1_D_POS_1 F1_CLIP 0 FOLD_POS
DCORE_F1_D_NEG_1 0 F1_CLIP FOLD_NEG
RCORE_R_F1_INPUT_0 FOLDER_DRIVE F1_SUM 100000
RCORE_R_F1_FEEDBACK_0 F1_OUT F1_SUM 100000
RCORE_R_F2_CLIP_FEED_0 F1_OUT F2_CLIP 10000
DCORE_F2_D_POS_1 F2_CLIP 0 FOLD_POS
DCORE_F2_D_NEG_1 0 F2_CLIP FOLD_NEG
RCORE_R_F2_INPUT_0 F1_OUT F2_SUM 100000
RCORE_R_F2_FEEDBACK_0 F2_OUT F2_SUM 100000
RCORE_R_F3_CLIP_FEED_0 F2_OUT F3_CLIP 10000
DCORE_F3_D_POS_1 F3_CLIP 0 FOLD_POS
DCORE_F3_D_NEG_1 0 F3_CLIP FOLD_NEG
RCORE_R_F3_INPUT_0 F2_OUT F3_SUM 100000
RCORE_R_F3_FEEDBACK_0 F3_OUT F3_SUM 100000
RCORE_R_F4_CLIP_FEED_0 F3_OUT F4_CLIP 10000
DCORE_F4_D_POS_1 F4_CLIP 0 FOLD_POS
DCORE_F4_D_NEG_1 0 F4_CLIP FOLD_NEG
RCORE_R_F4_INPUT_0 F3_OUT F4_SUM 100000
RCORE_R_F4_FEEDBACK_0 F4_OUT F4_SUM 100000
RCORE_R_OUTPUT_RF_0 PRE_AC OUTPUT_FB 70000
RCORE_R_OUTPUT_RG_0 OUTPUT_FB 0 10000
CCORE_AC_BANK0_0 PRE_AC AC_NODE 1e-07
CCORE_AC_BANK1_0 PRE_AC AC_NODE 1e-07
CCORE_AC_BANK2_0 PRE_AC AC_NODE 1e-07
CCORE_AC_BANK3_0 PRE_AC AC_NODE 1e-07
CCORE_AC_BANK4_0 PRE_AC AC_NODE 1e-07
CCORE_AC_BANK5_0 PRE_AC AC_NODE 1e-07
CCORE_AC_BANK6_0 PRE_AC AC_NODE 1e-07
CCORE_AC_BANK7_0 PRE_AC AC_NODE 1e-07
CCORE_AC_BANK8_0 PRE_AC AC_NODE 1e-07
CCORE_AC_BANK9_0 PRE_AC AC_NODE 1e-07
RCORE_R_AC_RETURN_0 AC_NODE 0 100000
RCORE_remote_buffer_J_W2_IN_LEVEL__R_ISO_0 C01cf3e_DRIVE LEVEL_REMOTE 100
RCORE_remote_buffer_J_W2_IN_LEVEL__R_FB_0 LEVEL_REMOTE C01cf3e_FB 10000
CCORE_remote_buffer_J_W2_IN_LEVEL__C_FAST_0 C01cf3e_DRIVE C01cf3e_FB 1e-10
RLEVEL_TOP LEVEL_REMOTE C629978_W 1u
RLEVEL_BOTTOM C629978_W 0 10k
RCORE_level_attenuator_C_W2_LEVEL_LEVEL__R_W_0 C629978_W C629978_W_SENSE 1000
RCORE_level_attenuator_C_W2_LEVEL_LEVEL__R_FAIL_0 C629978_W_SENSE 0 1e+07
RCORE_general_output_J_W2_IN_OUT__R_ISO_A_0 C92bfbf_DRIVE C92bfbf_ISO_MID 499
RCORE_general_output_J_W2_IN_OUT__R_ISO_B_0 C92bfbf_ISO_MID OUT_TIP 499
ECORE_PACK_OPA4197IPWR_0_4 CORE_PACK_OPA4197IPWR_0_IO_UNUSED4 0 0 CORE_PACK_OPA4197IPWR_0_IO_UNUSED4 1e6
ECORE_PACK_OPA4196IDR_1_1 CONTROL_NEG 0 0 CONTROL_SUM 1e6
ECORE_PACK_OPA4196IDR_1_2 CONTROL_RAW 0 0 CONTROL_INV 1e6
ECORE_PACK_OPA4196IDR_1_3 COMMAND 0 CONTROL_CLAMP COMMAND 1e6
ECORE_PACK_OPA4196IDR_1_4 TARGET 0 REF25 TARGET_SUM 1e6
BCORE_PACK_OPA4196IDR_2_1 BASE_DRIVE 0 V=10.5*tanh(1e5*(v(TARGET)-v(EMITTER))/10.5)
ECORE_PACK_OPA4196IDR_2_2 PRE_GAIN 0 0 PRE_GAIN_SUM 1e6
ECORE_PACK_OPA4196IDR_2_3 FOLDER_NEG 0 0 FOLDER_SUM 1e6
ECORE_PACK_OPA4196IDR_2_4 FOLDER_DRIVE 0 0 DRIVE_INV_SUM 1e6
ECORE_PACK_OPA4196IDR_3_1 F1_OUT 0 F1_CLIP F1_SUM 1e6
ECORE_PACK_OPA4196IDR_3_2 F2_OUT 0 F2_CLIP F2_SUM 1e6
ECORE_PACK_OPA4196IDR_3_3 F3_OUT 0 F3_CLIP F3_SUM 1e6
ECORE_PACK_OPA4196IDR_3_4 F4_OUT 0 F4_CLIP F4_SUM 1e6
ECORE_PACK_OPA4196IDR_4_1 PRE_AC 0 F4_OUT OUTPUT_FB 1e6
ECORE_PACK_OPA4196IDR_4_2 AC_BUFFER 0 AC_NODE AC_BUFFER 1e6
ECORE_PACK_OPA4196IDR_4_3 C01cf3e_DRIVE 0 AC_BUFFER C01cf3e_FB 1e6
ECORE_PACK_OPA4196IDR_4_4 LEVEL_OUT 0 C629978_W_SENSE LEVEL_OUT 1e6
ECORE_PACK_OPA4196IDR_5_4 C92bfbf_DRIVE 0 LEVEL_OUT C92bfbf_DRIVE 1e6
ELED_PACK_OPA4196IDR_0_4 LED_PACK_OPA4196IDR_0_IO_UNUSED4 0 0 LED_PACK_OPA4196IDR_0_IO_UNUSED4 1e6
XOTA0 IABC NC_0_2 OTA_OFFSET OTA_SIGNAL PRE_GAIN_SUM N_12V 0 NC_0_8 P_12V LM13700/NS
XOTA1 UNUSED_IABC NC_1_15 0 0 NC_1_12 N_12V 0 NC_1_9 P_12V LM13700/NS
.model GENERIC_PNP PNP(IS=1e-14 BF=200 VAF=100)
.model FOLD_POS D(IS=1e-09 N=1.8 RS=1 CJO=2p TT=4n)
.model FOLD_NEG D(IS=1n N=1.8 RS=1 CJO=2p TT=4n)
.model SCHOTTKY D(IS=1u N=1.1 RS=1 CJO=10p)
RLOAD OUT_TIP 0 100k
.options reltol=1e-5 abstol=1e-11
.control
set wr_singlescale
set wr_vecnames
dc VIN -5 5 .01
wrdata .circuit-cache/wavefolder-spice/wavefolder-dc-f0p25-b5.txt v(PRE_AC) v(PRE_GAIN) v(FOLDER_DRIVE) v(COMMAND) v(OUT_TIP) v(F1_OUT) v(F2_OUT) v(F3_OUT) v(F4_OUT) v(CONTROL_NEG) v(CONTROL_RAW) v(BASE_DRIVE)
quit
.endc
.end
