Sine shaper: generic matched BJT pair, ideal amplifiers; no AS3340 model
Vp P_12V 0 12
Vn N_12V 0 -12
Vtri TRI_SCALED 0 PWL(0 -5 0.0005 5 0.001 -5 0.0015 5 0.002 -5 0.0025 5 0.003 -5 0.0035 5 0.004 -5 0.0045 5 0.005 -5 0.0055 5 0.006 -5 0.0065 5 0.007 -5 0.0075 5 0.008 -5 0.0085 5 0.009 -5 0.0095 5 0.01 -5)
Voffset SINE_OFFSET 0 1.5
RR_SINE_ATTEN_0 TRI_SCALED SINE_BASE 68000
RR_SINE_BASE_GND_0 SINE_BASE 0 1000
RR_SINE_OFFSET_0 SINE_OFFSET SINE_BASE 1e+06
RR_SINE_TAIL_0 SINE_TAIL N_12V 10000
RR_SINE_COLLECTOR1_0 P_12V SINE_C1 10000
RR_SINE_COLLECTOR2_0 P_12V SINE_C2 10000
RR_SINE_DIFF_PLUS_0 SINE_C2 SINE_PLUS 100000
RR_SINE_DIFF_GROUND_0 SINE_PLUS 0 100000
RR_SINE_DIFF_MINUS_0 SINE_C1 SINE_MINUS 100000
RR_SINE_DIFF_FB_0 SINE_DIFF SINE_MINUS 100000
RR_SINE_GAIN_IN_0 SINE_DIFF SINE_GAIN_SUM 100000
RR_SINE_GAIN_FIXED_0 SIN_SCALED SINE_GAIN_TRIM 49900
RR_SINE_REF5_ISO_0 SINE_REF5_DRIVE SINE_REF5 100
RR_SINE_REF5_FB_0 SINE_REF5 SINE_REF5_FB 100
RR_SINE_REFN5_ISO_0 SINE_REFN5_DRIVE SINE_REFN5 100
RR_SINE_REFN5_FB_0 SINE_REFN5 SINE_REFN5_FB 100
EPACK_OPA4196IDR_3_1 SINE_DIFF 0 SINE_PLUS SINE_MINUS 1e6
EPACK_OPA4196IDR_3_2 SIN_SCALED 0 0 SINE_GAIN_SUM 1e6
Q1 SINE_C1 SINE_BASE SINE_TAIL GENERIC_PAIR
Q2 SINE_C2 0 SINE_TAIL GENERIC_PAIR
.model GENERIC_PAIR NPN(IS=1e-14 BF=300 VAF=100)
Rlevel SINE_GAIN_TRIM SINE_GAIN_SUM 5500
.tran 2u 10m
.measure tran sine_max MAX v(SIN_SCALED) FROM=5m TO=10m
.measure tran sine_min MIN v(SIN_SCALED) FROM=5m TO=10m
.measure tran sine_mean AVG v(SIN_SCALED) FROM=5m TO=10m
.four 1k v(SIN_SCALED)
.end
