Shared octave reference: ideal opamps/reference; no real precision claim
Vref Cd45723_RAW_5V 0 5
Vp P_12V 0 12
Vn N_12V 0 -12
Creference_generator_J_O1_1V_SHARED__C_IN_0 P_12V 0 1e-07
Creference_generator_J_O1_1V_SHARED__C_OUT_0 Cd45723_RAW_5V 0 1e-06
Rreference_generator_J_O1_1V_SHARED__R_INV_0 OSC_REF5 Cd45723_INV 10000
Rreference_generator_J_O1_1V_SHARED__R_FB_0 OSC_REFN5 Cd45723_INV 10000
Rreference_generator_J_O1_1V_SHARED__R_GTOP_0 OSC_REF5 Cd45723_GATE_RAW 22000
Rreference_generator_J_O1_1V_SHARED__R_GBOT_0 Cd45723_GATE_RAW 0 100000
Roctave_reference_J_O1_1V_SHARED__R1_0 OCT_BOTTOM C5c0054_T1 10000
Roctave_reference_J_O1_1V_SHARED__R2_0 C5c0054_T1 C5c0054_T2 10000
Roctave_reference_J_O1_1V_SHARED__R3_0 C5c0054_T2 C5c0054_T3 10000
Roctave_reference_J_O1_1V_SHARED__R4_0 C5c0054_T3 C5c0054_T4 10000
Roctave_reference_J_O1_1V_SHARED__R5_0 C5c0054_T4 OCT_TOP 10000
Roctave_reference_J_O1_1V_SHARED__R_GAIN_0 0 C5c0054_GAIN_SUM 10000
Roctave_reference_J_O1_1V_SHARED__R_FIXED_0 C5c0054_GAIN_SUM C5c0054_GAIN_TRIM 19100
Roctave_reference_J_O1_1V_SHARED__R_ONE_TOP_0 OSC_REF5 C5c0054_ONE_MID 20000
Roctave_reference_J_O1_1V_SHARED__R_ONE_BOT_0 C5c0054_ONE_RAW 0 10000
Roctave_reference_J_O1_1V_SHARED__R_N2_IN_0 C5c0054_ONE_V C5c0054_N2_SUM 10000
Roctave_reference_J_O1_1V_SHARED__R_N2_FB_0 OCT_BOTTOM C5c0054_N2_SUM 20000
Roctave_reference_J_O1_1V_SHARED__R_ONE_TOP_B_0 C5c0054_ONE_MID C5c0054_ONE_RAW 20000
EPACK_OPA4197IPWR_0_1 OSC_REF5 0 Cd45723_RAW_5V OSC_REF5 1e6
EPACK_OPA4197IPWR_0_2 OSC_REFN5 0 0 Cd45723_INV 1e6
EPACK_OPA4197IPWR_0_3 OSC_GATE_REF 0 Cd45723_GATE_RAW OSC_GATE_REF 1e6
EPACK_OPA4197IPWR_0_4 OSC_OCT0 0 OCT_BOTTOM OSC_OCT0 1e6
EPACK_OPA4197IPWR_1_1 OSC_OCT1 0 C5c0054_T1 OSC_OCT1 1e6
EPACK_OPA4197IPWR_1_2 OSC_OCT2 0 C5c0054_T2 OSC_OCT2 1e6
EPACK_OPA4197IPWR_1_3 OSC_OCT3 0 C5c0054_T3 OSC_OCT3 1e6
EPACK_OPA4197IPWR_1_4 OSC_OCT4 0 C5c0054_T4 OSC_OCT4 1e6
EPACK_OPA4197IPWR_2_1 OSC_OCT5 0 OCT_TOP OSC_OCT5 1e6
EPACK_OPA4197IPWR_2_2 OCT_TOP 0 C5c0054_ONE_V C5c0054_GAIN_SUM 1e6
EPACK_OPA4197IPWR_2_3 C5c0054_ONE_V 0 C5c0054_ONE_RAW C5c0054_ONE_V 1e6
EPACK_OPA4197IPWR_2_4 OCT_BOTTOM 0 0 C5c0054_N2_SUM 1e6
CC_DEC_reference_generator_J_O1_1V_SHARED__U_0_0 P_12V 0 1e-07
CC_DEC_PACK_OPA4197IPWR_0_0_0 P_12V 0 1e-07
CC_DEC_PACK_OPA4197IPWR_0_1_0 N_12V 0 1e-07
CC_DEC_PACK_OPA4197IPWR_1_0_0 P_12V 0 1e-07
CC_DEC_PACK_OPA4197IPWR_1_1_0 N_12V 0 1e-07
CC_DEC_PACK_OPA4197IPWR_2_0_0 P_12V 0 1e-07
CC_DEC_PACK_OPA4197IPWR_2_1_0 N_12V 0 1e-07
Rspan C5c0054_GAIN_TRIM OCT_TOP 900
.control
op
print v(osc_oct0) v(osc_oct1) v(osc_oct2) v(osc_oct3) v(osc_oct4) v(osc_oct5)
quit
.endc
.end
