Envelope model only: envelope-loop-curved-normal
* Actual packed NAND and DFF pin graph; analogue boundary is ideal.
.param ibias=500u
VVCC VCC 0 5
VCLOCK CLOCK 0 PULSE(0 5 25u 1n 1n 24.999u 50u)
VRESET RESET_N 0 PWL(0 0 5m 0 5.001m 5)
VASR ASR_RAW 0 0
VLOOP LOOP_RAW 0 5
VSHAPE CURVED 0 5
VSTAGE STAGE_FALL 0 0
VBUTTON TRIG_ACTIVE 0 0
VSIG SIG_GATE 0 PWL(0 0 10m 0 10.001m 5 55m 5 55.001m 0)
BN0 L001 0 V=5*(1-(v(SIG_GATE)>2.5)*(v(SIG_GATE)>2.5))
BN1 L002 0 V=5*(1-(v(TRIG_ACTIVE)>2.5)*(v(TRIG_ACTIVE)>2.5))
BN2 GATE_RAW 0 V=5*(1-(v(L001)>2.5)*(v(L002)>2.5))
BN3 L004 0 V=5*(1-(v(RISE_N)>2.5)*(v(HOLD_N)>2.5))
BN4 L005 0 V=5*(1-(v(L004)>2.5)*(v(L004)>2.5))
BN5 L006 0 V=5*(1-(v(L005)>2.5)*(v(FALL_N)>2.5))
BN6 IDLE 0 V=5*(1-(v(L006)>2.5)*(v(L006)>2.5))
BN7 L008 0 V=5*(1-(v(GATE)>2.5)*(v(GATE_PREV_N)>2.5))
BN8 L010 0 V=5*(1-(v(EOC)>2.5)*(v(EOC)>2.5))
BN9 L011 0 V=5*(1-(v(LOOP)>2.5)*(v(IDLE)>2.5))
BN10 L012 0 V=5*(1-(v(L011)>2.5)*(v(L011)>2.5))
BN11 L013 0 V=5*(1-(v(L012)>2.5)*(v(L010)>2.5))
BN12 START 0 V=5*(1-(v(L008)>2.5)*(v(L013)>2.5))
BN13 L016 0 V=5*(1-(v(ASR)>2.5)*(v(GATE_N)>2.5))
BN14 L017 0 V=5*(1-(v(RISE)>2.5)*(v(TOP_N)>2.5))
BN15 L018 0 V=5*(1-(v(L017)>2.5)*(v(L017)>2.5))
BN16 L019 0 V=5*(1-(v(L018)>2.5)*(v(L016)>2.5))
BN17 L021 0 V=5*(1-(v(START)>2.5)*(v(START)>2.5))
BN18 D_RISE 0 V=5*(1-(v(L021)>2.5)*(v(L019)>2.5))
BN19 L023 0 V=5*(1-(v(RISE)>2.5)*(v(TOP)>2.5))
BN20 L025 0 V=5*(1-(v(HOLD_N)>2.5)*(v(L023)>2.5))
BN21 L026 0 V=5*(1-(v(L021)>2.5)*(v(ASR)>2.5))
BN22 L027 0 V=5*(1-(v(L026)>2.5)*(v(L026)>2.5))
BN23 L028 0 V=5*(1-(v(L027)>2.5)*(v(GATE)>2.5))
BN24 L029 0 V=5*(1-(v(L028)>2.5)*(v(L028)>2.5))
BN25 L030 0 V=5*(1-(v(L029)>2.5)*(v(L025)>2.5))
BN26 D_HOLD 0 V=5*(1-(v(L030)>2.5)*(v(L030)>2.5))
BN27 L032 0 V=5*(1-(v(FALL)>2.5)*(v(BOTTOM_N)>2.5))
BN28 L034 0 V=5*(1-(v(ASR)>2.5)*(v(GATE)>2.5))
BN29 L036 0 V=5*(1-(v(TOP)>2.5)*(v(L034)>2.5))
BN30 L039 0 V=5*(1-(v(L036)>2.5)*(v(L016)>2.5))
BN31 L040 0 V=5*(1-(v(RISE)>2.5)*(v(L039)>2.5))
BN32 L042 0 V=5*(1-(v(HOLD)>2.5)*(v(L034)>2.5))
BN33 L044 0 V=5*(1-(v(L032)>2.5)*(v(L040)>2.5))
BN34 L045 0 V=5*(1-(v(L044)>2.5)*(v(L044)>2.5))
BN35 L046 0 V=5*(1-(v(L045)>2.5)*(v(L042)>2.5))
BN36 L047 0 V=5*(1-(v(L021)>2.5)*(v(L046)>2.5))
BN37 D_FALL 0 V=5*(1-(v(L047)>2.5)*(v(L047)>2.5))
BN38 L049 0 V=5*(1-(v(READY)>2.5)*(v(FALL)>2.5))
BN39 L050 0 V=5*(1-(v(L049)>2.5)*(v(L049)>2.5))
BN40 L051 0 V=5*(1-(v(L050)>2.5)*(v(BOTTOM)>2.5))
BN41 L052 0 V=5*(1-(v(L051)>2.5)*(v(L051)>2.5))
BN42 L053 0 V=5*(1-(v(L052)>2.5)*(v(L021)>2.5))
BN43 D_COMPLETE 0 V=5*(1-(v(L053)>2.5)*(v(L053)>2.5))
BN44 L055 0 V=5*(1-(v(STAGE_FALL)>2.5)*(v(FALL)>2.5))
BN45 L057 0 V=5*(1-(v(STAGE_FALL)>2.5)*(v(STAGE_FALL)>2.5))
BN46 L058 0 V=5*(1-(v(L057)>2.5)*(v(RISE)>2.5))
BN47 STAGE_HIGH 0 V=5*(1-(v(L055)>2.5)*(v(L058)>2.5))
BN48 L061 0 V=5*(1-(v(FALL)>2.5)*(v(BOTTOM_RAW)>2.5))
BN49 L063 0 V=5*(1-(v(READY)>2.5)*(v(L006)>2.5))
BN50 L064 0 V=5*(1-(v(L063)>2.5)*(v(L063)>2.5))
BN51 RESET_CAP 0 V=5*(1-(v(L064)>2.5)*(v(L061)>2.5))
BN52 L066 0 V=5*(1-(v(RISE)>2.5)*(v(TOP_RAW)>2.5))
BN53 HOLD_ENABLE 0 V=5*(1-(v(HOLD_N)>2.5)*(v(L066)>2.5))
BN54 L069 0 V=5*(1-(v(CURVED)>2.5)*(v(CURVED)>2.5))
BN55 L070 0 V=5*(1-(v(READY)>2.5)*(v(RISE)>2.5))
BN56 L071 0 V=5*(1-(v(L070)>2.5)*(v(L070)>2.5))
BN57 L072 0 V=5*(1-(v(L071)>2.5)*(v(L069)>2.5))
BN58 RISE_LINEAR 0 V=5*(1-(v(L072)>2.5)*(v(L072)>2.5))
BN59 L074 0 V=5*(1-(v(L071)>2.5)*(v(CURVED)>2.5))
BN60 RISE_CURVE 0 V=5*(1-(v(L074)>2.5)*(v(L074)>2.5))
BN61 L076 0 V=5*(1-(v(L050)>2.5)*(v(L069)>2.5))
BN62 FALL_LINEAR 0 V=5*(1-(v(L076)>2.5)*(v(L076)>2.5))
BN63 L078 0 V=5*(1-(v(L050)>2.5)*(v(CURVED)>2.5))
BN64 FALL_CURVE 0 V=5*(1-(v(L078)>2.5)*(v(L078)>2.5))
BN65 NOT_RISE 0 V=5*(1-(v(RISE)>2.5)*(v(RISE)>2.5))
BN66 NOT_FALL 0 V=5*(1-(v(FALL)>2.5)*(v(FALL)>2.5))
.subckt EDGE_FF D CLK CLR Q QN
BNCLK NC 0 V=5-v(CLK)
BDATA DATA 0 V=(v(CLR)>2.5 ? v(D) : 0)
SM DATA M NC 0 SWLOG
CM M 0 10p IC=0
BM MB 0 V=v(M)
SS MB S CLK 0 SWLOG
CS S 0 10p IC=0
BQ Q 0 V=(v(CLR)>2.5 ? (v(S)>2.5 ? 5 : 0) : 0)
BQN QN 0 V=5-v(Q)
.ends EDGE_FF
.model SWLOG SW(Ron=100 Roff=1e15 Vt=2.5 Vh=.1)
XFF0 VCC CLOCK RESET_N READY1 NCFF0 EDGE_FF
XFF1 READY1 CLOCK RESET_N READY NCFF1 EDGE_FF
XFF2 GATE_RAW CLOCK READY GATE_SYNC NCFF2 EDGE_FF
XFF3 GATE_SYNC CLOCK READY GATE GATE_N EDGE_FF
XFF4 ASR_RAW CLOCK READY ASR_SYNC NCFF4 EDGE_FF
XFF5 ASR_SYNC CLOCK READY ASR NCFF5 EDGE_FF
XFF6 LOOP_RAW CLOCK READY LOOP_SYNC NCFF6 EDGE_FF
XFF7 LOOP_SYNC CLOCK READY LOOP NCFF7 EDGE_FF
XFF8 GATE CLOCK READY NCQ8 GATE_PREV_N EDGE_FF
XFF9 TOP_RAW CLOCK READY TOP_SYNC NCFF9 EDGE_FF
XFF10 TOP_SYNC CLOCK READY TOP TOP_N EDGE_FF
XFF11 BOTTOM_RAW CLOCK READY BOTTOM_SYNC NCFF11 EDGE_FF
XFF12 BOTTOM_SYNC CLOCK READY BOTTOM BOTTOM_N EDGE_FF
XFF13 D_RISE CLOCK READY RISE RISE_N EDGE_FF
XFF14 D_HOLD CLOCK READY HOLD HOLD_N EDGE_FF
XFF15 D_FALL CLOCK READY FALL FALL_N EDGE_FF
XFF16 D_COMPLETE CLOCK READY COMPLETE NCFF16 EDGE_FF
BENV ENV_BUFFER 0 V=v(ENV_STORAGE)
SCT VCC TOP_STATE ENV_BUFFER 0 CMP_TOP
RCT TOP_STATE 0 10k
BTOP TOP_RAW 0 V=(v(TOP_STATE)>2.5 ? 5 : 0)
BINVERT ENV_NEG 0 V=-v(ENV_BUFFER)
SCB VCC BOTTOM_STATE ENV_NEG 0 CMP_BOTTOM
RCB BOTTOM_STATE 0 10k
BBOTTOM BOTTOM_RAW 0 V=(v(BOTTOM_STATE)>2.5 ? 5 : 0)
.model CMP_TOP SW(Ron=1 Roff=1e15 Vt=7.93564356436 Vh=.02475247525)
.model CMP_BOTTOM SW(Ron=1 Roff=1e15 Vt=-.075 Vh=.025)
CENV ENV_STORAGE 0 1e-07 IC=0
BRISE 0 RISE_CURRENT I=19.2*ibias*(v(RISE_LINEAR)>2.5 ? 9/900 : (v(RISE_CURVE)>2.5 ? (9-v(ENV_BUFFER))/900 : 0))
BFALL FALL_CURRENT 0 I=19.2*ibias*(v(FALL_LINEAR)>2.5 ? 9/900 : (v(FALL_CURVE)>2.5 ? (v(ENV_BUFFER)+1)/900 : 0))
RRISE RISE_CURRENT ENV_STORAGE 100
RFALL FALL_CURRENT ENV_STORAGE 100
VPEAK PEAK 0 8
SHOLD PEAK HC HOLD_ENABLE 0 SWLOG
RHOLD HC ENV_STORAGE 100
SIDLE ENV_STORAGE IC RESET_CAP 0 SWLOG
RIDLE IC 0 100
BTIME NOW 0 V=time
SLAST NOW LAST COMPLETE 0 SWLOG
CLAST LAST 0 10p IC=0
BEOC EOC 0 V=(v(READY)>2.5 && v(LAST)>.01 && time-v(LAST)<0.00329 ? 5 : 0)
BBIP BIP 0 V=1.25*v(ENV_BUFFER)-5
BRISE_LED RISE_LED 0 V=(v(RISE)>2.5 ? max(v(ENV_BUFFER),0)/16 : 0)
BFALL_LED FALL_LED 0 V=(v(FALL)>2.5 ? max(v(ENV_BUFFER),0)/16 : 0)
* LED proxy volts correspond to current across the 1k sense resistor.
.control
set wr_singlescale
set wr_vecnames
tran 5u 120m uic
wrdata .circuit-cache/envelope-spice/envelope-loop-curved-normal.txt v(ENV_BUFFER) v(RISE) v(HOLD) v(FALL) v(EOC) v(BIP) v(STAGE_HIGH) v(RISE_LED) v(FALL_LED)
quit
.endc
.end
