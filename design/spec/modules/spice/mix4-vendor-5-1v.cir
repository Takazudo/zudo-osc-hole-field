MIX4 vendor single OTA; ideal summer/TIA and imposed bias 0.0005 A
.include "design/spec/modules/spice/filter-model/LM13700.MOD"
VP P_12V 0 12
VN N_12V 0 -12
VIN IN 0 SIN(0 1 1k) AC 1
R1 IN SUM_NODE 100k
R2 IN SUM_NODE 100k
R3 IN SUM_NODE 100k
R4 IN SUM_NODE 100k
RF SUM_PRELEVEL SUM_NODE 50k
ESUM SUM_PRELEVEL 0 0 SUM_NODE 1e6
RATTEN SUM_PRELEVEL OTA_SIGNAL 100k
RATTEN_G OTA_SIGNAL 0 100
ROFF OTA_OFFSET 0 1k
IABC P_12V IABC1 0.0005
XOTA IABC1 DIODE OTA_SIGNAL OTA_OFFSET OTA_CURRENT N_12V 0 BUFFER_OUT P_12V LM13700/NS
RFB SUM_OUT FB_TRIM 100k
RTRIM FB_TRIM OTA_CURRENT 4200
ETIA SUM_OUT 0 0 OTA_CURRENT 1e6
RLOAD SUM_OUT 0 100k
.tran 1u 4m
.measure tran out_max MAX v(SUM_OUT) FROM=2m TO=4m
.measure tran out_min MIN v(SUM_OUT) FROM=2m TO=4m
.end
