Raw-output scaling: ideal 12 V core amplitudes assumed
Vref OSC_REF5 0 5
Vtri TRI_RAW 0 PWL(0 0 0.0005 4 0.001 0 0.0015 4 0.002 0 0.0025 4 0.003 0)
Vsaw SAW_RAW 0 PWL(0 0 .000999 8 .001 0 .001999 8 .002 0 .002999 8 .003 0)
RR_TRI_BIAS_TOP_0 OSC_REF5 TRI_BIAS 250000
RR_TRI_BIAS_BOT_0 TRI_BIAS 0 100000
RR_TRI_IN_0 TRI_RAW TRI_SUM 40000
RR_TRI_FB_0 TRI_SCALED TRI_SUM 100000
RR_SAW_BIAS_TOP_0 OSC_REF5 SAW_BIAS 125000
RR_SAW_BIAS_BOT_0 SAW_BIAS 0 100000
RR_SAW_IN_0 SAW_RAW SAW_SUM 80000
RR_SAW_FB_0 SAW_SCALED SAW_SUM 100000
EPACK_OPA4196IDR_3_1 TRI_SCALED 0 TRI_BIAS TRI_SUM 1e6
EPACK_OPA4196IDR_3_2 SAW_SCALED 0 SAW_BIAS SAW_SUM 1e6
.tran 1u 3m
.measure tran tri_max MAX v(TRI_SCALED) FROM=1m TO=3m
.measure tran tri_min MIN v(TRI_SCALED) FROM=1m TO=3m
.measure tran saw_max MAX v(SAW_SCALED) FROM=1m TO=3m
.measure tran saw_min MIN v(SAW_SCALED) FROM=1m TO=3m
.end
