MIX4 vendor single OTA; ideal summer/TIA and imposed bias 0.00025 A
.include "design/spec/modules/spice/filter-model/LM13700.MOD"
VP P_12V 0 12
VN N_12V 0 -12
VREFP REF5 0 5
VREFN REFN5 0 -5
VIN IN 0 SIN(0 5 1k) AC 5
R1 IN SUM_NODE 100k
R2 IN SUM_NODE 100k
R3 IN SUM_NODE 100k
R4 IN SUM_NODE 100k
RF SUM_PRELEVEL SUM_NODE 50k
ESUM SUM_PRELEVEL 0 0 SUM_NODE 1e6
RATTEN SUM_PRELEVEL OTA_SIGNAL 100k
RATTEN_G OTA_SIGNAL 0 100
RPOT_TOP REF5 OFFSET_W 2300
RPOT_BOTTOM OFFSET_W REFN5 7700
RFEED OFFSET_W OTA_OFFSET 1meg
ROFF OTA_OFFSET 0 1k
IABC P_12V CURRENT_SOURCE 0.00025
R_IABC_LIMIT CURRENT_SOURCE IABC1 10k
XOTA IABC1 DIODE OTA_SIGNAL OTA_OFFSET OTA_CURRENT N_12V 0 BUFFER_OUT P_12V LM13700/NS
RFB SUM_OUT FB_TRIM 100k
RTRIM FB_TRIM OTA_CURRENT 9000
ETIA SUM_OUT 0 0 OTA_CURRENT 1e6
RLOAD SUM_OUT 0 100k
.tran 1u 4m
.measure tran out_max MAX v(SUM_OUT) FROM=2m TO=4m
.measure tran out_min MIN v(SUM_OUT) FROM=2m TO=4m
.end
