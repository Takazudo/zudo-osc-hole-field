N1 BROWN small-signal shaping; ideal opamps
VNOISE input 0 DC 0 AC 1
RRECON input recon 1k
CRECON recon 0 10n
CAC recon ac 100n
RBLEED ac 0 100k
EINPUT buffered 0 ac buffered 1e6
RIN buffered sum 100k
RLEAK out sum 1Meg
CLEAK out sum 10n
EOUT out 0 0 sum 1e6
.control
set wr_singlescale
set wr_vecnames
ac dec 100 1 100k
wrdata .circuit-cache/noise-spice/brown.txt db(v(out))
quit
.endc
.end
